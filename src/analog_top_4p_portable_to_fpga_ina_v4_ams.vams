`include "constants.vams"
`include "disciplines.vams"

// =============================================================================
// Módulo Verilog-AMS para la Arquitectura v4 (Opción 3 Calibración de Magnitud)
// Modelado Analógico Riguroso del Autoshunt ADG4612 + Banco de 4 Resistencias
// (R1=2000, R2=1000, R3=500, R4=200 Ohm) con Conmutación en Paralelo:
// - Decadas 10-100Hz y 100-1kHz: SW1 ON                 -> R_sh = 2000 Ohm
// - Década 1k-10kHz           : SW1, SW2 ON            -> R_sh = 2000 || 1000 = 666.67 Ohm
// - Década 10k-100kHz         : SW2, SW3 ON            -> R_sh = 1000 || 500 = 333.33 Ohm
// - Década 100k-1MHz          : SW2, SW3, SW4 ON       -> R_sh = 1000 || 500 || 200 = 125.0 Ohm
// =============================================================================

module analog_top_4p_portable_to_fpga_ina_v4_ams (
    inout electrical node_gen_p,
    inout electrical node_gen_n,
    inout electrical node_adc1,
    inout electrical node_adc2,
    input electrical ctrl_r_f1,
    input electrical ctrl_r_f2,
    input electrical ctrl_r_s1,
    input electrical ctrl_r_s2,
    input electrical ctrl_c_f1,
    input electrical ctrl_c_f2,
    input electrical ctrl_c_s1,
    input electrical ctrl_c_s2,
    input electrical ctrl_sw1,
    input electrical ctrl_sw2,
    input electrical ctrl_sw3,
    input electrical ctrl_sw4,
    input electrical ctrl_rext,
    input electrical ctrl_rint,
    input electrical ctrl_c_mem
);
    // Parámetros Físicos v4
    parameter real C_LEAK       = 10.0e-12;
    parameter real MUTUAL_L     = 2.5e-7;
    parameter real R_IN_INA     = 1.0e12;
    parameter real C_IN_INA     = 3.0e-12;
    parameter real R_BIAS_INA   = 100.0e6;
    parameter real INA_GAIN     = 1.0;
    parameter real C_F          = 2.0e-12;
    parameter real C_DC         = 10.0e-6;
    parameter real R_DC         = 100.0e3;
    parameter real R_IN_TIA_INV = 50.0;

    // Parámetros del Multiplexor Analógico ADG4612 y Banco de Resistencias Shunt Base
    parameter real R_SW_ON  = 4.5;       // Resistencia ON típica del ADG4612 (4.5 Ohm)
    parameter real R_SW_OFF = 1.0e9;     // Resistencia OFF típica del ADG4612 (1 Gohm)
    parameter real C_SW     = 10.0e-12;  // Capacitancia parásita por canal switch (~10 pF)
    parameter real R_SH1    = 2000.0;    // R1 = 2000 Ohm
    parameter real R_SH2    = 1000.0;    // R2 = 1000 Ohm
    parameter real R_SH3    = 500.0;     // R3 = 500 Ohm
    parameter real R_SH4    = 200.0;     // R4 = 200 Ohm

    // Nodos internos topológicos v4
    electrical node_cdc_p, node_cdc_n;     // Nodos tras desacoplamiento DC
    electrical node_A, node_B;             // Fronteras del tejido
    electrical node_tissue_int;            // Nodo interno RC del tejido (C_mem + R_int)
    electrical node_ina_in1, node_ina_in2; // Entradas físicas del INA AD8421
    electrical node_tia_in;                // Entrada inversora virtual TIA AD844

    // Nodos de los terminales Source (S1..S4) del ADG4612 conectados a R1..R4
    electrical node_s1, node_s2, node_s3, node_s4;

    real r_f1_ohm, r_f2_ohm, r_s1_ohm, r_s2_ohm;
    real c_f1_f, c_f2_f, c_s1_f, c_s2_f;
    real rext_ohm, rint_ohm, c_mem_f;

    real sw1_val, sw2_val, sw3_val, sw4_val;
    real g_sw1, g_sw2, g_sw3, g_sw4;

    // Rama Force para derivar la corriente de excitación en la inductancia mutua
    branch (node_cdc_p, node_A) b_force_p;

    analog begin
        // 1. Lectura de controles dinámicos de electrodos y tejido
        r_f1_ohm      = V(ctrl_r_f1);
        r_f2_ohm      = V(ctrl_r_f2);
        r_s1_ohm      = V(ctrl_r_s1);
        r_s2_ohm      = V(ctrl_r_s2);
        c_f1_f        = V(ctrl_c_f1);
        c_f2_f        = V(ctrl_c_f2);
        c_s1_f        = V(ctrl_c_s1);
        c_s2_f        = V(ctrl_c_s2);
        rext_ohm      = V(ctrl_rext);
        rint_ohm      = V(ctrl_rint);
        c_mem_f       = V(ctrl_c_mem);

        // Lectura continua de las entradas de selección del multiplexor ADG4612
        sw1_val       = V(ctrl_sw1);
        sw2_val       = V(ctrl_sw2);
        sw3_val       = V(ctrl_sw3);
        sw4_val       = V(ctrl_sw4);

        // Clamping de seguridad
        if (r_f1_ohm < 1.0e-3) r_f1_ohm = 1.0e-3;
        if (r_f2_ohm < 1.0e-3) r_f2_ohm = 1.0e-3;
        if (r_s1_ohm < 1.0e-3) r_s1_ohm = 1.0e-3;
        if (r_s2_ohm < 1.0e-3) r_s2_ohm = 1.0e-3;
        if (c_f1_f < 0.0) c_f1_f = 0.0;
        if (c_f2_f < 0.0) c_f2_f = 0.0;
        if (c_s1_f < 0.0) c_s1_f = 0.0;
        if (c_s2_f < 0.0) c_s2_f = 0.0;
        if (rext_ohm < 1.0e-3) rext_ohm = 1.0e-3;
        if (rint_ohm < 1.0e-3) rint_ohm = 1.0e-3;
        if (c_mem_f < 1.0e-15) c_mem_f = 1.0e-15;

        if (sw1_val < 0.0) sw1_val = 0.0; else if (sw1_val > 1.0) sw1_val = 1.0;
        if (sw2_val < 0.0) sw2_val = 0.0; else if (sw2_val > 1.0) sw2_val = 1.0;
        if (sw3_val < 0.0) sw3_val = 0.0; else if (sw3_val > 1.0) sw3_val = 1.0;
        if (sw4_val < 0.0) sw4_val = 0.0; else if (sw4_val > 1.0) sw4_val = 1.0;

        // Conductancia de cada uno de los 4 switches analógicos del ADG4612
        g_sw1 = (1.0 - sw1_val) / R_SW_OFF + sw1_val / R_SW_ON;
        g_sw2 = (1.0 - sw2_val) / R_SW_OFF + sw2_val / R_SW_ON;
        g_sw3 = (1.0 - sw3_val) / R_SW_OFF + sw3_val / R_SW_ON;
        g_sw4 = (1.0 - sw4_val) / R_SW_OFF + sw4_val / R_SW_ON;

        // 2. Acoplamiento de Excitación Balanceada (Bloqueo DC C_dc + R_dc)
        I(node_gen_p, node_cdc_p) <+ C_DC * ddt(V(node_gen_p, node_cdc_p));
        I(node_gen_n, node_cdc_n) <+ C_DC * ddt(V(node_gen_n, node_cdc_n));
        I(node_cdc_p) <+ V(node_cdc_p) / R_DC;
        I(node_cdc_n) <+ V(node_cdc_n) / R_DC;

        // Fugas capacitivas en los cables de excitación
        I(node_gen_p) <+ C_LEAK * ddt(V(node_gen_p));
        I(node_gen_n) <+ C_LEAK * ddt(V(node_gen_n));

        // 3. Lazo Force (Contactos R_f1||C_f1 y R_f2||C_f2)
        I(b_force_p) <+ V(b_force_p) / r_f1_ohm + c_f1_f * ddt(V(b_force_p));
        I(node_B, node_tia_in) <+ V(node_B, node_tia_in) / r_f2_ohm + c_f2_f * ddt(V(node_B, node_tia_in));

        // 4. Modelo de Tejido Biológico R_ext || (R_int + C_mem)
        I(node_A, node_B) <+ V(node_A, node_B) / rext_ohm;
        I(node_A, node_tissue_int) <+ c_mem_f * ddt(V(node_A, node_tissue_int));
        I(node_tissue_int, node_B) <+ V(node_tissue_int, node_B) / rint_ohm;

        // 5. Lazo Sense (Contactos R_s1||C_s1 y R_s2||C_s2)
        I(node_A, node_ina_in1) <+ V(node_A, node_ina_in1) / r_s1_ohm + c_s1_f * ddt(V(node_A, node_ina_in1));
        I(node_B, node_ina_in2) <+ V(node_B, node_ina_in2) / r_s2_ohm + c_s2_f * ddt(V(node_B, node_ina_in2));

        // 6. Etapa de Entrada y Salida INA AD8421 (con Inductancia Mutua M*di/dt)
        I(node_ina_in1, node_ina_in2) <+ V(node_ina_in1, node_ina_in2) / R_IN_INA + C_IN_INA * ddt(V(node_ina_in1, node_ina_in2));
        I(node_ina_in1) <+ V(node_ina_in1) / R_BIAS_INA;
        I(node_ina_in2) <+ V(node_ina_in2) / R_BIAS_INA;
        V(node_adc1) <+ INA_GAIN * ((V(node_ina_in1) - V(node_ina_in2)) + MUTUAL_L * ddt(I(b_force_p)));

        // 7. Resistencias Shunt Base R1..R4 conectadas de S1..S4 a GND
        I(node_s1) <+ V(node_s1) / R_SH1;
        I(node_s2) <+ V(node_s2) / R_SH2;
        I(node_s3) <+ V(node_s3) / R_SH3;
        I(node_s4) <+ V(node_s4) / R_SH4;

        // 8. Interruptores del ADG4612 entre D1..D4 (node_adc2) y S1..S4 (node_s1..s4)
        I(node_adc2, node_s1) <+ V(node_adc2, node_s1) * g_sw1 + C_SW * ddt(V(node_adc2, node_s1));
        I(node_adc2, node_s2) <+ V(node_adc2, node_s2) * g_sw2 + C_SW * ddt(V(node_adc2, node_s2));
        I(node_adc2, node_s3) <+ V(node_adc2, node_s3) * g_sw3 + C_SW * ddt(V(node_adc2, node_s3));
        I(node_adc2, node_s4) <+ V(node_adc2, node_s4) * g_sw4 + C_SW * ddt(V(node_adc2, node_s4));

        // 9. Etapa TIA AD844 (Tierra Virtual de 50 Ohm en node_tia_in e inyección en nodo TZ node_adc2)
        I(node_tia_in, node_cdc_n) <+ V(node_tia_in, node_cdc_n) / R_IN_TIA_INV;
        I(node_adc2) <+ C_F * ddt(V(node_adc2));
        I(node_adc2) <+ -(V(node_tia_in, node_cdc_n) / R_IN_TIA_INV);
    end
endmodule
