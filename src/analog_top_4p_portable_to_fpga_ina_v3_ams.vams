`include "constants.vams"
`include "disciplines.vams"

// =============================================================================
// Módulo Verilog-AMS para la arquitectura v3 (INAs + 2 ADCs + TIA AD844 + Excitación Balanceada)
// =============================================================================

module analog_top_4p_portable_to_fpga_ina_v3_ams (
    inout electrical node_gen_p,
    inout electrical node_gen_n,
    inout electrical node_adc1,
    inout electrical node_adc2,
    input electrical ctrl_r_f1,
    input electrical ctrl_r_f2,
    input electrical ctrl_r_s1,
    input electrical ctrl_r_s2,
    input electrical ctrl_c_f1,
    input electrical ctrl_c_f2,
    input electrical ctrl_c_s1,
    input electrical ctrl_c_s2,
    input electrical ctrl_autoshunt,
    input electrical ctrl_rext,
    input electrical ctrl_rint,
    input electrical ctrl_c_mem
);
    // Parámetros Físicos v3
    parameter real C_LEAK       = 10.0e-12;
    parameter real MUTUAL_L     = 2.5e-7;
    parameter real R_IN_INA     = 1.0e12;
    parameter real C_IN_INA     = 3.0e-12;
    parameter real R_BIAS_INA   = 100.0e6;
    parameter real INA_GAIN     = 1.0;
    parameter real C_F          = 2.0e-12;
    parameter real C_DC         = 10.0e-6;
    parameter real R_DC         = 100.0e3;
    parameter real R_IN_TIA_INV = 50.0;

    // Nodos internos topológicos v3
    electrical node_cdc_p, node_cdc_n;     // Nodos tras desacoplamiento DC
    electrical node_A, node_B;             // Fronteras del tejido
    electrical node_tissue_int;            // Nodo interno RC del tejido (C_mem + R_int)
    electrical node_s1_int, node_s2_int;   // Nodos de lectura intermedia Sense
    electrical node_ina_in1, node_ina_in2; // Entradas físicas del INA AD8421
    electrical node_tia_in;                // Entrada inversora virtual TIA AD844

    real r_f1_ohm, r_f2_ohm, r_s1_ohm, r_s2_ohm;
    real c_f1_f, c_f2_f, c_s1_f, c_s2_f;
    real autoshunt_ohm, rext_ohm, rint_ohm, c_mem_f;

    // Rama Force para derivar la corriente de excitación en la inductancia mutua
    branch (node_cdc_p, node_A) b_force_p;

    analog begin
        // 1. Lectura de controles dinámicos
        r_f1_ohm      = V(ctrl_r_f1);
        r_f2_ohm      = V(ctrl_r_f2);
        r_s1_ohm      = V(ctrl_r_s1);
        r_s2_ohm      = V(ctrl_r_s2);
        c_f1_f        = V(ctrl_c_f1);
        c_f2_f        = V(ctrl_c_f2);
        c_s1_f        = V(ctrl_c_s1);
        c_s2_f        = V(ctrl_c_s2);
        autoshunt_ohm = V(ctrl_autoshunt);
        rext_ohm      = V(ctrl_rext);
        rint_ohm      = V(ctrl_rint);
        c_mem_f       = V(ctrl_c_mem);

        // Clamping de seguridad
        if (r_f1_ohm < 1.0e-3) r_f1_ohm = 1.0e-3;
        if (r_f2_ohm < 1.0e-3) r_f2_ohm = 1.0e-3;
        if (r_s1_ohm < 1.0e-3) r_s1_ohm = 1.0e-3;
        if (r_s2_ohm < 1.0e-3) r_s2_ohm = 1.0e-3;
        if (c_f1_f < 0.0) c_f1_f = 0.0;
        if (c_f2_f < 0.0) c_f2_f = 0.0;
        if (c_s1_f < 0.0) c_s1_f = 0.0;
        if (c_s2_f < 0.0) c_s2_f = 0.0;
        if (autoshunt_ohm < 1.0e-3) autoshunt_ohm = 1.0e-3;
        if (rext_ohm < 1.0e-3) rext_ohm = 1.0e-3;
        if (rint_ohm < 1.0e-3) rint_ohm = 1.0e-3;
        if (c_mem_f < 1.0e-15) c_mem_f = 1.0e-15;

        // 2. Acoplamiento de Excitación Balanceada (Bloqueo DC C_dc + R_dc)
        I(node_gen_p, node_cdc_p) <+ C_DC * ddt(V(node_gen_p, node_cdc_p)) + V(node_gen_p, node_cdc_p) / 1.0e6;
        I(node_gen_n, node_cdc_n) <+ C_DC * ddt(V(node_gen_n, node_cdc_n)) + V(node_gen_n, node_cdc_n) / 1.0e6;
        I(node_cdc_p) <+ V(node_cdc_p) / R_DC;
        I(node_cdc_n) <+ V(node_cdc_n) / R_DC;

        // Fugas capacitivas en los cables de excitación
        I(node_gen_p) <+ C_LEAK * ddt(V(node_gen_p));
        I(node_gen_n) <+ C_LEAK * ddt(V(node_gen_n));

        // 3. Lazo Force (Contactos R_f1||C_f1 y R_f2||C_f2)
        I(b_force_p) <+ V(b_force_p) / r_f1_ohm + c_f1_f * ddt(V(b_force_p));
        I(node_B, node_tia_in) <+ V(node_B, node_tia_in) / r_f2_ohm + c_f2_f * ddt(V(node_B, node_tia_in));

        // 4. Modelo de Tejido Biológico R_ext || (R_int + C_mem)
        I(node_A, node_B) <+ V(node_A, node_B) / rext_ohm;
        I(node_A, node_tissue_int) <+ c_mem_f * ddt(V(node_A, node_tissue_int));
        I(node_tissue_int, node_B) <+ V(node_tissue_int, node_B) / rint_ohm;

        // 5. Lazo Sense (Contactos R_s1||C_s1 y R_s2||C_s2)
        I(node_A, node_s1_int) <+ V(node_A, node_s1_int) / r_s1_ohm + c_s1_f * ddt(V(node_A, node_s1_int));
        I(node_B, node_s2_int) <+ V(node_B, node_s2_int) / r_s2_ohm + c_s2_f * ddt(V(node_B, node_s2_int));

        // 6. Inductancia Mutua (Coupling entre la corriente Force+ y la tensión Sense)
        V(node_s1_int, node_ina_in1) <+  MUTUAL_L * ddt(V(b_force_p) / r_f1_ohm);
        V(node_s2_int, node_ina_in2) <+ -MUTUAL_L * ddt(V(b_force_p) / r_f1_ohm);

        // 7. Etapa de Entrada INA AD8421 (C_in_ina, R_in_ina, R_bias_ina) y Salida (node_adc1)
        I(node_ina_in1, node_ina_in2) <+ V(node_ina_in1, node_ina_in2) / R_IN_INA + C_IN_INA * ddt(V(node_ina_in1, node_ina_in2));
        I(node_ina_in1) <+ V(node_ina_in1) / R_BIAS_INA;
        I(node_ina_in2) <+ V(node_ina_in2) / R_BIAS_INA;
        V(node_adc1) <+ INA_GAIN * (V(node_ina_in1) - V(node_ina_in2));

        // 8. Etapa TIA AD844 (Tierra Virtual de 50 Ohm en node_tia_in y Salida TZ en node_adc2)
        I(node_tia_in) <+ V(node_tia_in) / R_IN_TIA_INV;
        I(node_adc2) <+ V(node_adc2) / autoshunt_ohm + C_F * ddt(V(node_adc2));
        I(node_adc2) <+ -(V(node_tia_in) / R_IN_TIA_INV);
    end
endmodule
