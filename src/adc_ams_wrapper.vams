`include "disciplines.vams"

module adc_ams_wrapper(
    inout electrical node_adc, // CAMBIO CRÍTICO: Ahora es inout para poder drenar corriente (Carga del instrumento)
    input logic clk,
    output reg [13:0] digital_out
);
    parameter real R_IN  = 1.0e6;
    parameter real C_IN  = 20.0e-12; // Actualizado a 20pF por defecto
    parameter real FS    = 125.0e6;
    parameter real V_REF = 1.0;
    parameter real V_CM  = 0.9;

    real v_sampled;
    real v_filtered;
    real v_norm;
    localparam real ALPHA = (1.0 / FS) / ((1.0 / (2.0 * 3.1415 * 50.0e6)) + (1.0 / FS));

    // --- CARGA FÍSICA DEL INSTRUMENTO ---
    // Aquí es donde ocurre la "magia" del artefacto. El ADC ya no es un observador ideal.
    analog begin
        I(node_adc) <+ (V(node_adc) / R_IN) + C_IN * ddt(V(node_adc));
    end

    initial begin
        digital_out = 14'd0;
        v_filtered = 0.0;
        v_sampled = 0.0;
    end

    always @(posedge clk) begin
        v_sampled = V(node_adc);
        v_filtered = v_filtered + ALPHA * (v_sampled - v_filtered);
        v_norm = v_filtered / V_REF;

        if (v_norm >= 1.0)
            digital_out <= 14'h1FFF;
        else if (v_norm <= -1.0)
            digital_out <= 14'h2000;
        else
            digital_out <= $rtoi(v_norm * 8192.0);
    end
endmodule
